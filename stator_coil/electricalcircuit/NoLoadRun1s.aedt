# Ansys Electronics Desktop project, version 2019.2
project variables:
  $ActiveResistanceStator = 0.0014305943ohm  # Stator active resistance
  $ActiveResistanceRotor = 0.042259981ohm  # Rotor active resistance
  $TestTime = 10s  # Test time
  $NoLoadTime = 1s  # Initial time of no-load running
  $VoltageRotor = 30.8V  # Rotor voltage

design New (Maxwell Circuit)
components:
  Winding_145 = Winding(Name=WindingStatorAX)
  Winding_146 = Winding(Name=WindingStatorBY)
  Ammeter_151 = Ammeter()
  Ammeter_154 = Ammeter()
  Voltmeter_172 = Voltmeter()
  Voltmeter_176 = Voltmeter()
  Res_178 = Res(R=$ActiveResistanceStator)
  Res_179 = Res(R=$ActiveResistanceStator)
  Winding_182 = Winding(Name=WindingStatorCZ)
  Res_185 = Res(R=$ActiveResistanceStator)
  Ammeter_188 = Ammeter()
  Voltmeter_191 = Voltmeter()
  Ammeter_251 = Ammeter()
  SW_I_261 = SW_I(MOD=M1 ID_I=VAmmeter251)
  SW_I_264 = SW_I(MOD=M1 ID_I=VAmmeter251)
  SW_I_265 = SW_I(MOD=M1 ID_I=VAmmeter251)
  IPulse_275 = IPulse(Tr=0s I1=0A I2=2A Td=$NoLoadTime Tf=0s Pw=$TestTime Period=$TestTime+1)
  SW_IModel_298 = SW_IModel(DeviceName=M1 Ion=1A Ioff=0A Ron=1uOhm Roff=1GOhm)
nets:
  0: Winding_145.0, Voltmeter_172.0, Ammeter_251.0, IPulse_275.1, Voltmeter_176.0, Winding_146.0, Winding_182.0, Voltmeter_191.0
  net_164: Voltmeter_176.1, Winding_146.1, Ammeter_154.0
  net_170: Winding_182.1, Voltmeter_191.1, Ammeter_188.0
  net_235: Ammeter_251.1, IPulse_275.0
  net_246: Winding_145.1, Voltmeter_172.1, Ammeter_151.0
  net_250: Ammeter_151.1, Res_178.0
  net_251: Res_179.0, Ammeter_154.1
  net_252: Res_185.0, Ammeter_188.1
  net_253: SW_I_261.0, Res_178.1
  net_254: Res_179.1, SW_I_264.0
  net_255: Res_185.1, SW_I_265.0
  net_256: SW_I_261.1, SW_I_264.1, SW_I_265.1
